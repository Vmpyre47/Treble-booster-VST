Independent PNP Rangemaster netlist, si, Boost rotation=0.5
Vbat supply 0 -9
Vin input 0 DC 0 AC 1 SIN(0 0.3 3000)
C1 input base 5n
R1 base supply 470k
R2 base 0 68k
Q1 collector base emitter device
R3 emitter 0 3.9k
C3 emitter 0 47u
Rtop supply wiper 909.090909090909
Rbottom wiper collector 9090.90909090909
C2 wiper output 10n
Rload output 0 1meg
C4 supply 0 47u
Ileak emitter collector 0
.model device PNP(IS=6.7f BF=160 BR=3 TNOM=26.827)
.temp 26.827
.options reltol=1e-7 abstol=1e-13 vntol=1e-9
.control
set wr_singlescale
set wr_vecnames
op
print v(base) v(emitter) v(collector)
ac lin 1 100 100
print vdb(output)
ac lin 1 1000 1000
print vdb(output)
ac lin 1 5000 5000
print vdb(output)
tran 5.208333333333u 0.5 0 1u
linearize v(output)
wrdata si-0.5-spice.txt v(output)
quit
.endc
.end
