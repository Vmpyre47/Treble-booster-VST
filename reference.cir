* Dallas Rangemaster, positive-ground reference, nominal germanium model
* Circuit source: see CIRCUIT.md. This is an optional SPICE reference, not a test result.
* Set B from .000001 to .999999; 1 is max Boost (wiper at collector).
.param B=0.999999
VBAT supply 0 DC -9
VIN input 0 SIN(0 0.1 1000) AC 1
C1 input base 5n
R1 base supply 470k
R2 base 0 68k
Q1 collector base emitter OC44_NOMINAL
R3 emitter 0 3.9k
C3 emitter 0 47u
RVtop supply wiper {10000*B}
RVbottom wiper collector {10000*(1-B)}
C2 wiper output 10n
RLOAD output 0 1meg
C4 supply 0 47u
* Explicit internal collector-emitter leakage for the nominal Q1 model.
* ILEAK is a device-model contribution, not an extra original resistor or part.
ILEAK emitter collector DC 15u
.model OC44_NOMINAL PNP(IS=80n BF=90 BR=2)
.op
.ac dec 40 20 20000
.tran 1u 50m
.end
